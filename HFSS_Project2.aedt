# Ansys Electronics Desktop project, version 2024.2
project variables:
  $vias_to_vias_w = 0.5m
  $spacing = 150um
  $signal_t = 18um
  $ground_width = 1mm-$spacing-$signal_width/2
  $pitch = 1mm/5
  $height_port = 5*$package_t
  $package_t = 184um
  $number_viases = 12
  $signal_length = 793um
  $signal_width = 185um
  $vias_rad = 100um
  $via_pad_rad = 150um
  $ground_length = 1mm
  $width_port = 2*$spacing+$signal_width+2*$ground_width
  $bellow_plate_width = 2*$spacing+$signal_width
  $ground_length_updated = 1.1m
  $bottom_plate_length = $signal_length-$spacing
  $ground_connection_rad = 50u
project datasets:
  $Au_Typical_20: (-273.15, 0.74045802) (-196.15, 0.74045802) (99.85, 1) (726.85, 1)
materials:
  air: permittivity=1.0006 permeability=1.0000004
  aluminum: permeability=1.000021 conductivity=38000000
  CMD195: permittivity=4.6
  copper: permeability=0.999991 conductivity=58000000
  Core-RO4350B: permittivity=3.66 dielectric_loss_tangent=0.0037
  FR4_epoxy: permittivity=4.4 dielectric_loss_tangent=0.02
  gallium_arsenide: permittivity=12.9
  gallium_arsenide - Copy: permittivity=12.9
  gold: permeability=0.99996 conductivity=41000000
  Hitachi GEA-705G: permittivity=3.6 dielectric_loss_tangent=0.01
  MGC_GHPL_970LF: permittivity=3.35 dielectric_loss_tangent=0.004
  MQS-0418: permittivity=3.8
  pec: conductivity=1e+30
  Preg-RO4450F: permittivity=3.52 dielectric_loss_tangent=0.004
  Rogers RO4350 (tm): permittivity=3.66 dielectric_loss_tangent=0.004
  silicon: permittivity=11.9
  silicon_dioxide: permittivity=4
  silicon_nitrate: permittivity=7
  solder: conductivity=7000000
  vacuum: permittivity=1
  Au-Typical

design Die_Wirebonding (HFSS, HFSS Modal Network, model units mm)
options: Allow_Material_Override
variables:
  TL_W = 50um
  TL_L = 1mm
  TL_T = 18um
  PCB_W = 2mm
  TL_Gap = 60um
  PCB_T = 35um
  Die_L = 150um
  Die_Edge = 85um
  Die_EdgetoFlag = 85um
  Wirebond_Pad_Clearance = 95um
  Epoxy_T = 25um
  Die_T = 104um
  Die_Dummy_T = 100um
  Die_Pad_W = 200um
  Die_Pad_Gap = 50um
  D1 = 35um
  M1 = 18um
  M2 = 18um
  D2 = 60um
  M3 = 18um
  M4 = 18um
  D3 = 35um
  Package_Pad = 300um
  W = 13mil
  copper_pad_height = copper_pad
  copper_pad = 4um
  diameter_wirebond = 25u
geometry:
  D1 [Hitachi GEA-705G] = box(corner=(-PCB_W/2, -TL_L, -TL_T), size=(PCB_W, TL_L+Die_EdgetoFlag+Wirebond_Pad_Clearance+Die_L, -D1))
  PS_M2_Die_Paddle [copper] = box(corner=(-PCB_W/2, Wirebond_Pad_Clearance, -M1-D1), size=(PCB_W, Die_L+Die_EdgetoFlag, -M2))
  PS_M1_Die_Paddle [copper] = box(corner=(-PCB_W/2, Wirebond_Pad_Clearance, 0mm), size=(PCB_W, Die_L+Die_EdgetoFlag, -M1))
  Solder_Paste [solder] = box(corner=(-PCB_W/2, Wirebond_Pad_Clearance+Die_EdgetoFlag, 0mm), size=(PCB_W, Die_L, Epoxy_T))
  Die_GND_Plane [copper] = box(corner=(-PCB_W /2, Wirebond_Pad_Clearance+Die_EdgetoFlag, Epoxy_T), size=(PCB_W, Die_L, Die_T-Die_Dummy_T))
  Die_Body [silicon] = box(corner=(-PCB_W/2, Wirebond_Pad_Clearance +Die_EdgetoFlag, Epoxy_T+Die_T), size=(PCB_W, Die_L, -Die_Dummy_T))
  Die_Pad [copper] = box(corner=(-Die_Pad_W/2, Die_Pad_Gap+Wirebond_Pad_Clearance+Die_EdgetoFlag, Epoxy_T+Die_T), size=(Die_Pad_W, Die_L-Die_Pad_Gap, 4um))
  Port2 = rectangle(corner=(-Die_Pad_W*10/2, Wirebond_Pad_Clearance +Die_EdgetoFlag+Die_L, Epoxy_T+Die_T-Die_Dummy_T), z_size=Die_Dummy_T*10, x_size=Die_Pad_W*10)
  GND_Vias_Paddle_12 [copper] = cylinder(axis=Z, base_centre=(0mm, Wirebond_Pad_Clearance +Die_EdgetoFlag+70um, -TL_T), radius=50um, height=-D1-M2-D2-M3-D3)
  GND_Vias_Paddle, GND_Vias_Paddle_2, GND_Vias_Paddle_1, GND_Vias_Paddle_3, GND_Vias_Paddle_4, GND_Vias_Paddle_6 [copper] = GND_Vias_Paddle_12.duplicate_along_line(step=(-0.147mm, 0mm, 0mm), total=7)
  GND_Vias_Paddle_5, GND_Vias_Paddle_8, GND_Vias_Paddle_7, GND_Vias_Paddle_10, GND_Vias_Paddle_9, GND_Vias_Paddle_11 [copper] = GND_Vias_Paddle_12.duplicate_along_line(step=(0.147mm, 0mm, 0mm), total=7)
  Region [vacuum] = region(percentage_offset: +X=5, -X=5, +Y=0, -Y=0, +Z=5, -Z=5)
  M2_Fill [Hitachi GEA-705G] = box(corner=(-PCB_W/2, -TL_L, -TL_T-D1), size=(PCB_W, TL_L+Die_EdgetoFlag+Wirebond_Pad_Clearance+Die_L, -M2))
  D2 [Hitachi GEA-705G] = box(corner=(-PCB_W/2, -TL_L, -TL_T-D1-M2), size=(PCB_W, TL_L+Die_EdgetoFlag+Wirebond_Pad_Clearance+Die_L, -D2))
  PS_M3_Die_Paddle [copper] = box(corner=(-PCB_W/2, Wirebond_Pad_Clearance, -M1-D1-M2-D2), size=(PCB_W, Die_L+Die_EdgetoFlag, -M3))
  M3_Fill [Hitachi GEA-705G] = box(corner=(-PCB_W/2, -TL_L, -TL_T-D1-M2-D2), size=(PCB_W, TL_L+Die_EdgetoFlag+Wirebond_Pad_Clearance+Die_L, -M3))
  D3 [Hitachi GEA-705G] = box(corner=(-PCB_W/2, -TL_L, -TL_T-D1-M2-D2-M3), size=(PCB_W, TL_L+Die_EdgetoFlag+Wirebond_Pad_Clearance+Die_L, -D3))
  PS_M4_Die_Paddle [copper] = box(corner=(-PCB_W/2, Wirebond_Pad_Clearance, -M1-D1-M2-D2-M3-D3), size=(PCB_W, Die_L+Die_EdgetoFlag, -M4))
  Package_Pad1 [copper] = box(corner=(-Package_Pad/2, -TL_L+50um, -M1-D1-M2-D2-M3-D3-M4), size=(Package_Pad, Package_Pad, M4))
  Package_Pad2 [copper] = box(corner=(-Package_Pad/2-500um, -TL_L+50um, -M1-D1-M2-D2-M3-D3-M4), size=(Package_Pad, Package_Pad, M4))
  Package_Pad3 [copper] = box(corner=(-Package_Pad/2+500um, -TL_L+50um, -M1-D1-M2-D2-M3-D3-M4), size=(Package_Pad, Package_Pad, M4))
  Solder_Bump1 [solder] = cylinder(axis=Z, base_centre=(0, -TL_L+50um+Package_Pad/2, -M1-D1-M2-D2-M3-D3-M4-200um), radius=250um/2, height=200um)
  Solder_Bump2 [solder] = cylinder(axis=Z, base_centre=(-500um, -TL_L+50um+Package_Pad/2, -M1-D1-M2-D2-M3-D3-M4-200um), radius=250um/2, height=200um)
  Solder_Bump3 [solder] = cylinder(axis=Z, base_centre=(500um, -TL_L+50um+Package_Pad/2, -M1-D1-M2-D2-M3-D3-M4-200um), radius=250um/2, height=200um)
  PCB_D1 [Rogers RO4350 (tm)] = box(corner=(-PCB_W*2/2, -0.5mm, -0.7mil-6.6mil), size=(PCB_W*2, 1mm, 6.6mil))
  PCB_M1_S [copper] = box(corner=(-W/2, -0.5mm, -0.7mil), size=(W, 1mm, 0.7mil))
  Cylinder4 [copper] = cylinder(axis=Z, base_centre=(1.7mm, -2.7mm, 0.16764mm), radius=4mil, height=-0.16764mm)
  Cylinder4.move(-0.635mm, 0.6825mm, -2.7755576e-17mm)
  Cylinder4_1, Cylinder4_2 [copper] = Cylinder4.duplicate_along_line(step=(0mm, -0.3175mm, 0mm), total=3)
  Cylinder4.move(0mm, 0.135mm, 0mm)
  Cylinder4_3 [copper] = Cylinder4.duplicate_mirror(point=(1.7mm, -2.7mm, 0.18542mm), normal=(-1mm, 0mm, 0mm))
  Cylinder4.move(-1.7mm, 2.2mm, -0.18542mm)
  Cylinder4_1.move(0mm, 0.135mm, 0mm)
  Cylinder4_1_1 [copper] = Cylinder4_1.duplicate_mirror(point=(1.7mm, -2.7mm, 0.18542mm), normal=(-1mm, 0mm, 0mm))
  Cylinder4_1.move(-1.7mm, 2.2mm, -0.18542mm)
  Cylinder4_2.move(0mm, 0.135mm, 0mm)
  Cylinder4_2_1 [copper] = Cylinder4_2.duplicate_mirror(point=(1.7mm, -2.7mm, 0.18542mm), normal=(-1mm, 0mm, 0mm))
  [Cylinder4_2, Cylinder4_3, Cylinder4_1_1, Cylinder4_2_1].move(-1.7mm, 2.2mm, -0.18542mm)
  Port1 = rectangle(corner=(-3*(2*7mil+W)/2, -0.5mm, 0mm), z_size=6*6.6mil, x_size=3*(2*7mil+W))
  Port1.move(0mm, 0mm, -0.18542mm)
  PCB_M1_G1 [copper] = box(corner=(-0.3175mm, 0.5mm, -0.01778mm), size=(-1.6825mm, -1mm, 0.01778mm))
  PCB_M1_G1_1 [copper] = PCB_M1_G1.duplicate_mirror(point=(0mm, 0mm, 0mm), normal=(-1mm, 0mm, 0mm))
  PCB_M2_GND [copper] = box(corner=(-2mm, -0.5mm, -0.18542mm), size=(4mm, 1mm, -0.7mil))
  Cylinder5 = cylinder(axis=Z, base_centre=(1.7mm, -2.7mm, 0.16764mm), radius=4mil, height=-0.16764mm)
  Cylinder5.move(-0.635mm, 0.6825mm, -2.7755576e-17mm)
  Cylinder4_4, Cylinder4_5 [copper] = Cylinder5.duplicate_along_line(step=(0mm, -0.3175mm, 0mm), total=3)
  Cylinder5.delete()
  Cylinder4_4.move(0mm, 0.135mm, 0mm)
  Cylinder4_4.move(-1.7mm, 2.2mm, -0.18542mm)
  Cylinder4_4.move(-0.3175mm, 0.15875mm, 0mm)
  Cylinder4_4_1 [copper] = Cylinder4_4.duplicate_mirror(point=(0mm, 0mm, 0mm), normal=(1mm, 0mm, 0mm))
  Cylinder4_5.move(0mm, 0.135mm, 0mm)
  Cylinder4_5.move(-1.7mm, 2.2mm, -0.18542mm)
  Cylinder4_5.move(-0.3175mm, 0.15875mm, 0mm)
  Cylinder4_5_1 [copper] = Cylinder4_5.duplicate_mirror(point=(0mm, 0mm, 0mm), normal=(1mm, 0mm, 0mm))
  [PCB_D1, PCB_M1_S, Cylinder4, Cylinder4_1, Cylinder4_2, Cylinder4_3, Cylinder4_1_1, Cylinder4_2_1, Port1, PCB_M1_G1, PCB_M2_GND, PCB_M1_G1_1, Cylinder4_4, Cylinder4_5, Cylinder4_4_1, Cylinder4_5_1].move(0mm, -1.125mm, -0.402mm)
  vias_signal [copper] = cylinder(axis=Z, base_centre=(0, -TL_L + 200um, -M1-D1-M2-D2-M3-D3), radius=$vias_rad, height=-(-M1-D1-M2-D2-M3-D3))
  Bondwire1 [copper] = bondwire(WireType=JEDEC_4Points WireDiameter=diameter_wirebond NumSides=10 XPadPos=0mm YPadPos=diameter_wirebond/2+Wirebond_Pad_Clearance+Die_Pad_Gap+Die_EdgetoFlag ZPadPos=Epoxy_T+copper_pad_height+Die_T XDir=0mm YDir=-0.18mm ZDir=0mm Distance=260um+diameter_wirebond/2 h1=0.03mm h2=(Epoxy_T+copper_pad_height+Die_T) alpha=80deg beta=0 WhichAxis=Z)
  vias_pad [copper] = cylinder(axis=Z, base_centre=(0, -TL_L + 200um, 0), radius=$via_pad_rad, height=-M1)
  signal_trace [copper] = box(corner=(-$signal_width /2, -TL_L + 200um, 0), size=($signal_width, $signal_length, -M1))
  ground_top2 [copper] = box(corner=($spacing+ $signal_width/2, 0mm, 0mm), size=($ground_width, -$ground_length_updated, -M1))
  ground_top2_1 [copper] = ground_top2.duplicate_along_line(step=(-(2*$spacing+$signal_width+$ground_width), 0mm, 0mm), total=2)
  ground_top5 [copper] = box(corner=($spacing+ $signal_width/2, 0mm, -M1-D1-M2-D2-M3-D3), size=($ground_width, -$ground_length_updated, -M1))
  ground_top5_1 [copper] = ground_top5.duplicate_along_line(step=(-(2*$spacing+$signal_width+$ground_width), 0mm, 0mm), total=2)
  ground_viases [copper] = cylinder(axis=Z, base_centre=($vias_to_vias_w, -TL_L + 200um, -M1-D1-M2-D2-M3-D3), radius=$vias_rad, height=-(-M1-D1-M2-D2-M3-D3))
  ground_bot1 = box(corner=(-$bellow_plate_width/2, 0mm, -M1-D1), size=($bellow_plate_width, -$bottom_plate_length, -M1))
  ground_bot2 [copper] = ground_bot1.duplicate_along_line(step=(0mm, 0mm, -D2-M2), total=3)  # copies kept: 1
  ground_bot3 [copper] = box(corner=(-$bellow_plate_width/2, 0mm, -M1-D1-M2-D2-M3-D3), size=($bellow_plate_width, -$bottom_plate_length, -M1))
  [ground_top5_1, ground_top5, ground_bot1].move(0mm, (0.18-0.085) mm, 0mm)
  ground_bot1.delete()
  [ground_bot2, ground_bot3, ground_top2].move(0mm, (0.18-0.085) mm, 0mm)
  ground_top2_1.move(0mm, 0.18mm-0.085mm, 0mm)
  Package_Pad4 = box(corner=(-Package_Pad/2 -$spacing, -TL_L+50um-$spacing, -M1-D1-M2-D2-M3-D3-M4), size=(Package_Pad+2*$spacing, Package_Pad+2*$spacing, M4))
  vias_pad1 = cylinder(axis=Z, base_centre=(0, -TL_L + 200um, 0), radius=$via_pad_rad+$spacing, height=-$package_t)
  vias_pad1_1 = vias_pad1.copy()
  ground_top2.subtract(vias_pad1_1)
  vias_pad1_2 = vias_pad1.copy()
  ground_top2_1.subtract(vias_pad1_2)
  vias_pad1_7 = vias_pad1.copy()
  ground_top5.subtract(vias_pad1_7)
  ground_top5_1.subtract(vias_pad1)
  ground_top4_1 [copper] = box(corner=($spacing+ $signal_width/2, 0mm, -M1-D1-D2-M2), size=($ground_width, -$ground_length_updated, -M1))
  ground_top4 [copper] = ground_top4_1.duplicate_along_line(step=(-(2*$spacing+$signal_width+$ground_width), 0mm, 0mm), total=2)
  ground_top4_1.move(0mm, (0.18-0.085) mm, 0mm)
  vias_pad2 = cylinder(axis=Z, base_centre=(0, -TL_L + 200um, 0), radius=$via_pad_rad+$spacing, height=-$package_t)
  vias_pad1_8 = vias_pad2.copy()
  ground_top4_1.subtract(vias_pad1_8)
  ground_top4.move(0mm, (0.18-0.085) mm, 0mm)
  vias_pad1_9 = vias_pad2.copy()
  ground_top4.subtract(vias_pad1_9)
  vias_pad2.delete()
  Package_Pad4_1 = Package_Pad4.copy()
  ground_top5.subtract(Package_Pad4_1)
  ground_top5_1.subtract(Package_Pad4)
  ground_top3 [copper] = box(corner=($spacing+ $signal_width/2, 0mm, -M1-D1), size=($ground_width, -$ground_length_updated, -M1))
  ground_top3_1 [copper] = ground_top3.duplicate_along_line(step=(-(2*$spacing+$signal_width+$ground_width), 0mm, 0mm), total=2)
  ground_top3.move(0mm, (0.18-0.085) mm, 0mm)
  vias_pad3 = cylinder(axis=Z, base_centre=(0, -TL_L + 200um, 0), radius=$via_pad_rad+$spacing, height=-$package_t)
  vias_pad1_3 = vias_pad3.copy()
  ground_top3.subtract(vias_pad1_3)
  ground_top3_1.move(0mm, (0.18-0.085) mm, 0mm)
  vias_pad1_4 = vias_pad3.copy()
  ground_top3_1.subtract(vias_pad1_4)
  vias_pad3.delete()
  ground_bot4 [copper] = box(corner=(-$bellow_plate_width/2, 0mm, -M1-D1), size=($bellow_plate_width, -$bottom_plate_length, -M1))
  ground_bot4.move(0mm, (0.18-0.085) mm, 0mm)
  ground_viases_2..ground_viases_5 [copper] = ground_viases.duplicate_along_line(step=(0mm, $pitch, 0mm), total=5)
  ground_viases_6 [copper] = ground_viases.duplicate_along_line(step=(-1mm, 0mm, 0mm), total=2)
  ground_viases_2_1 [copper] = ground_viases_2.duplicate_along_line(step=(-1mm, 0mm, 0mm), total=2)
  ground_viases_3_1 [copper] = ground_viases_3.duplicate_along_line(step=(-1mm, 0mm, 0mm), total=2)
  ground_viases_4_1 [copper] = ground_viases_4.duplicate_along_line(step=(-1mm, 0mm, 0mm), total=2)
  ground_viases_5_1 [copper] = ground_viases_5.duplicate_along_line(step=(-1mm, 0mm, 0mm), total=2)
  Bondwire1_1 [copper] = Bondwire1.duplicate_along_line(step=(0.04mm, 0mm, 0mm), total=2)
  Bondwire1_4 [copper] = Bondwire1.duplicate_along_line(step=(0.08mm, 0mm, 0mm), total=2)
  Bondwire1_5, Bondwire1_6 [copper] = Bondwire1.duplicate_along_line(step=(-0.04mm, 0mm, 0mm), total=3)
  group Die_MMIC = Solder_Paste, Die_GND_Plane, Die_Body, Die_Pad
  group Package_Substrate = D1, PS_M2_Die_Paddle, PS_M1_Die_Paddle, GND_Vias_Paddle_12, GND_Vias_Paddle, GND_Vias_Paddle_2, GND_Vias_Paddle_1, GND_Vias_Paddle_3, GND_Vias_Paddle_4, GND_Vias_Paddle_6, GND_Vias_Paddle_5, GND_Vias_Paddle_8, GND_Vias_Paddle_7, GND_Vias_Paddle_10, GND_Vias_Paddle_9, GND_Vias_Paddle_11, M2_Fill, D2, PS_M3_Die_Paddle, M3_Fill, D3, PS_M4_Die_Paddle, Package_Pad1, Package_Pad2, Package_Pad3, Solder_Bump1, Solder_Bump2, Solder_Bump3
  group PCB = PCB_D1, PCB_M1_S, Cylinder4, Cylinder4_1, Cylinder4_2, Cylinder4_3, Cylinder4_1_1, Cylinder4_2_1, PCB_M1_G1, PCB_M2_GND, PCB_M1_G1_1, Cylinder4_4, Cylinder4_5, Cylinder4_4_1, Cylinder4_5_1
boundaries and excitations:
  Rad1: Radiation Objects=Region
  Port2: Wave Port Faces=Port1.face(at (0, -1.625, -0.0845)) WavePortType=Terminal NumModes=1 Modes{Mode1{CharImp=Zpi}}
  Port1: Wave Port Faces=Port2.face WavePortType=Terminal NumModes=1 Modes{Mode1{CharImp=Zpi}}
  reference conductors: Die_GND_Plane
mesh:
  initial mesh: GlobalSurfApproximation{CurvedSurfaceApproxChoice=UseSlider SliderMeshSettings=4}
setups:
  Setup1: HfssDriven Frequency=50GHz MaxDeltaS=0.02 MaximumPasses=15 MinimumPasses=1 MinimumConvergedPasses=1 PercentRefinement=30 BasisOrder=1 PortAccuracy=2 DrivenSolverType="Direct Solver"
    sweep Sweep: 1GHz to 50GHz step 0.05GHz; Type=Interpolating SaveFields InterpTolerance=0.5 InterpMaxSolns=250 InterpUsePortImped=false PassivityErrorTolerance=0.0001
source amplitudes:
  Port2:1: 1V 0deg
  Port1:1: 0V 0deg
optimetrics:
  ParametricSetup1: Parametric Sim._Setups=[Setup1]
    sweep $signal_width: LIN 185um 200um 5um
    sweep $spacing: LIN 130um 160um 10um
reports:
  S Parameter Plot 1: dB(S(Port1,Port1)) vs Freq on Setup1 : Sweep [$spacing=all $signal_length=all $signal_width=all $ground_length_updated=all]
  S11 signal length modulation: dB(S(Port1,Port1)) vs Freq on Setup1 : Sweep [$spacing=150um $signal_length=all $signal_width=185um $ground_length_updated=0.0011m]
  S11 and S22 Parameter: dB(S(Port1,Port1)), dB(S(Port2,Port2)) vs Freq on Setup1 : Sweep [$spacing=150um $signal_length=793um $signal_width=185um $ground_length_updated=0.0011m]; markers m1 at 50GHz, m2 at 31.8GHz
  S22 Parameter: dB(S(Port2,Port2)) vs Freq on Setup1 : Sweep [$spacing=150um $signal_length=793um $signal_width=185um $ground_length_updated=0.0011m]
